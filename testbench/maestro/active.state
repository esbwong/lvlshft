ADE simulation setup
Test edtest00_SIM_lvlshft_1: edtest00/SIM_lvlshft/schematic, simulator spectre
  Models: $SPECTRE_MODEL_PATH/12LP_Spectre.lib[tt]
  Variables: vddhi = 1.8; vddlo = 0.8; wireopt = 9
  Temperature: 27
  Analysis tran: stop=3u errpreset=conservative
  Signals: /vin, /vout, /ILVL/vddlv (terminal), /ILVL/vddhv (terminal)
Run mode: Single Run, Sweeps and Corners
