ADE simulation setup
Run mode: Single Run, Sweeps and Corners
Tests:
  edtest00_SIM_lvlshft_1: edtest00/SIM_lvlshft/schematic, simulator spectre
    Variables: wireopt = 9; vddhi = 1.8; vddlo = 0.8
